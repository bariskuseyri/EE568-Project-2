# Ansys Electronics Desktop project, version 2020.1
materials:
  XG196/96: permeability{HUnit=A_per_meter BUnit=tesla curve (-690000, 0) (-663113.52, 0.048797862) (-635337.77, 0.097595724) (-606627.88, 0.14639359) (-576935.93, 0.19519145) (-546210.65, 0.24398931) (-514397.15, 0.29278717) (-481436.56, 0.34158503) (-447265.71, 0.39038289) (-411816.7, 0.43918076) (-375016.43, 0.48797862) (-333347.94, 0.54110533) (-291679.45, 0.5934675) (-250010.95, 0.64582967) (-208342.46, 0.69819184) (-166673.97, 0.75055402) (-125005.48, 0.80291619) (-83336.985, 0.85527836) (-41668.492, 0.90764053) (0, 0.96)}
  M19_24G: permeability{HUnit=A_per_meter BUnit=tesla curve (0, 0) (22.28, 0.05) (25.46, 0.1) (31.83, 0.15) (47.74, 0.36) (63.66, 0.54) (79.57, 0.65) (159.15, 0.99) (318.3, 1.2) (477.46, 1.28) (636.61, 1.33) (795.77, 1.36) (1591.5, 1.44) (3183, 1.52) (4774.6, 1.58) (6366.1, 1.63) (7957.7, 1.67) (15915, 1.8) (31830, 1.9) (111407, 2) (190984, 2.1) (350138, 2.3) (509292, 2.5)} conductivity=1960000 core_loss_type="Electrical Steel" core_loss_kh=164.2 core_loss_kc=1.3 core_loss_ke=1.72 mass_density=7650
  NdFe30: permittivity=1 permeability=1.044573 conductivity=625000 magnetic_coercivity{Magnitude=-838000A_per_meter DirComp1=1 DirComp2=0 DirComp3=0} lande_g_factor=2 mass_density=7550
  Arnold_Magnetics_N35_60C: permeability{HUnit=A_per_meter BUnit=tesla curve (-687000, -0.8938) (-684000, -0.1201) (-680000, 0.0385) (-671000, 0.1708) (-663000, 0.216) (-655000, 0.2446) (-647000, 0.2664) (-639000, 0.2845) (-631000, 0.3005) (-623000, 0.3151) (-614000, 0.3289) (-606000, 0.342) (-598000, 0.3547) (-590000, 0.367) (-582000, 0.3791) (-574000, 0.3909) (-566000, 0.4025) (-558000, 0.4141) (-550000, 0.4255) (-542000, 0.4368) (-534000, 0.448) (-526000, 0.4591) (-517000, 0.4702) (-509000, 0.4812) (-501000, 0.4922) (-493000, 0.5032) (-485000, 0.5141) (-477000, 0.525) (-469000, 0.5359) (-461000, 0.5467) (-453000, 0.5575) (-445000, 0.5683) (-437000, 0.5791) (-429000, 0.5898) (-420000, 0.6006) (-412000, 0.6113) (-404000, 0.622) (-396000, 0.6327) (-388000, 0.6434) (-380000, 0.6541) (-372000, 0.6648) (-364000, 0.6755) (-356000, 0.6861) (-348000, 0.6968) (-340000, 0.7075) (-331000, 0.7181) (-323000, 0.7287) (-315000, 0.7394) (-307000, 0.75) (-299000, 0.7606) (-291000, 0.7712) (-283000, 0.7819) (-275000, 0.7925) (-267000, 0.8031) (-259000, 0.8137) (-251000, 0.8243) (-243000, 0.8349) (-234000, 0.8455) (-226000, 0.8561) (-218000, 0.8667) (-210000, 0.8772) (-202000, 0.8878) (-194000, 0.8984) (-186000, 0.909) (-178000, 0.9196) (-170000, 0.9301) (-162000, 0.9407) (-154000, 0.9513) (-146000, 0.9619) (-137000, 0.9724) (-129000, 0.983) (-121000, 0.9936) (-113000, 1.0041) (-105000, 1.0147) (-97000, 1.0253) (-89000, 1.0358) (-81000, 1.0464) (-73000, 1.0569) (-65000, 1.0675) (-57000, 1.0781) (-49000, 1.0886) (-40000, 1.0992) (-32000, 1.1097) (-24000, 1.1203) (-16000, 1.1308) (-8000, 1.1414) (0, 1.1519)} conductivity=555555.5556 magnetic_coercivity{Magnitude=-905300A_per_meter DirComp1=1 DirComp2=0 DirComp3=0} mass_density=7500
  Arnold_Magnetics_N48_60C: permeability{HUnit=A_per_meter BUnit=tesla curve (-687000, -0.8938) (-684000, 0.0007) (-680000, 0.1835) (-671000, 0.3347) (-663000, 0.3853) (-655000, 0.4168) (-647000, 0.4403) (-639000, 0.4596) (-631000, 0.4765) (-623000, 0.4918) (-614000, 0.5061) (-606000, 0.5196) (-598000, 0.5326) (-590000, 0.5452) (-582000, 0.5575) (-574000, 0.5695) (-566000, 0.5813) (-558000, 0.593) (-550000, 0.6045) (-542000, 0.616) (-534000, 0.6273) (-526000, 0.6385) (-517000, 0.6497) (-509000, 0.6608) (-501000, 0.6719) (-493000, 0.6829) (-485000, 0.6939) (-477000, 0.7049) (-469000, 0.7158) (-461000, 0.7267) (-453000, 0.7375) (-445000, 0.7484) (-437000, 0.7592) (-429000, 0.77) (-420000, 0.7808) (-412000, 0.7915) (-404000, 0.8023) (-396000, 0.813) (-388000, 0.8237) (-380000, 0.8345) (-372000, 0.8452) (-364000, 0.8559) (-356000, 0.8665) (-348000, 0.8772) (-340000, 0.8879) (-331000, 0.8986) (-323000, 0.9092) (-315000, 0.9199) (-307000, 0.9305) (-299000, 0.9412) (-291000, 0.9518) (-283000, 0.9624) (-275000, 0.9731) (-267000, 0.9837) (-259000, 0.9943) (-251000, 1.0049) (-243000, 1.0155) (-234000, 1.0261) (-226000, 1.0367) (-218000, 1.0473) (-210000, 1.0579) (-202000, 1.0685) (-194000, 1.0791) (-186000, 1.0897) (-178000, 1.1003) (-170000, 1.1109) (-162000, 1.1215) (-154000, 1.132) (-146000, 1.1426) (-137000, 1.1532) (-129000, 1.1638) (-121000, 1.1744) (-113000, 1.1849) (-105000, 1.1955) (-97000, 1.2061) (-89000, 1.2166) (-81000, 1.2272) (-73000, 1.2378) (-65000, 1.2483) (-57000, 1.2589) (-49000, 1.2695) (-40000, 1.28) (-32000, 1.2906) (-24000, 1.3011) (-16000, 1.3117) (-8000, 1.3222) (0, 1.3328)} conductivity=555555.5556 magnetic_coercivity{Magnitude=-880000A_per_meter DirComp1=1 DirComp2=0 DirComp3=0} mass_density=7500
  Arnold_Magnetics_N45_60C: permeability{HUnit=A_per_meter BUnit=tesla curve (-687000, -0.8938) (-684000, -0.0311) (-680000, 0.1453) (-671000, 0.2916) (-663000, 0.3407) (-655000, 0.3715) (-647000, 0.3945) (-639000, 0.4135) (-631000, 0.4301) (-623000, 0.4453) (-614000, 0.4594) (-606000, 0.4729) (-598000, 0.4858) (-590000, 0.4983) (-582000, 0.5105) (-574000, 0.5225) (-566000, 0.5343) (-558000, 0.5459) (-550000, 0.5574) (-542000, 0.5688) (-534000, 0.5801) (-526000, 0.5913) (-517000, 0.6025) (-509000, 0.6136) (-501000, 0.6246) (-493000, 0.6356) (-485000, 0.6466) (-477000, 0.6575) (-469000, 0.6684) (-461000, 0.6793) (-453000, 0.6901) (-445000, 0.701) (-437000, 0.7118) (-429000, 0.7226) (-420000, 0.7333) (-412000, 0.7441) (-404000, 0.7548) (-396000, 0.7656) (-388000, 0.7763) (-380000, 0.787) (-372000, 0.7977) (-364000, 0.8084) (-356000, 0.8191) (-348000, 0.8297) (-340000, 0.8404) (-331000, 0.8511) (-323000, 0.8617) (-315000, 0.8724) (-307000, 0.883) (-299000, 0.8936) (-291000, 0.9043) (-283000, 0.9149) (-275000, 0.9255) (-267000, 0.9361) (-259000, 0.9468) (-251000, 0.9574) (-243000, 0.968) (-234000, 0.9786) (-226000, 0.9892) (-218000, 0.9998) (-210000, 1.0104) (-202000, 1.021) (-194000, 1.0316) (-186000, 1.0421) (-178000, 1.0527) (-170000, 1.0633) (-162000, 1.0739) (-154000, 1.0845) (-146000, 1.0951) (-137000, 1.1056) (-129000, 1.1162) (-121000, 1.1268) (-113000, 1.1373) (-105000, 1.1479) (-97000, 1.1585) (-89000, 1.1691) (-81000, 1.1796) (-73000, 1.1902) (-65000, 1.2007) (-57000, 1.2113) (-49000, 1.2219) (-40000, 1.2324) (-32000, 1.243) (-24000, 1.2535) (-16000, 1.2641) (-8000, 1.2746) (0, 1.2852)} conductivity=555555.5556 magnetic_coercivity{Magnitude=-905300A_per_meter DirComp1=1 DirComp2=0 DirComp3=0} mass_density=7500

design assm-1 (RMxprt, Adjust-Speed Synchronous Machine, model units mm)
machine:
  Machine: FrictionLoss=12W WindLoss=0W ReferenceSpeed=1000rpm NumberOfPoles=22 RotorPosition=true ControlType=3 CircuitType=Y3
  Circuit: TriggerPulseWidth=120deg TransistorDrop=2V DiodeDrop=2V ModulationIndex=0.8 CarrierFrequencyTimes=100
  Stator: SkewWidth=0 NumberOfSlots=27 LaminationSectors=0 PressBoardThickness=0mm OuterDiameter=100mm InnerDiameter=60mm Length=100mm StackingFactor=0.95 SteelType=M19_24G SlotType=2
  Rotor: OuterDiameter=59mm InnerDiameter=24mm Length=100mm SteelType=M19_24G PoleType=1 StackingFactor=0.95
  Shaft:
  Stator Slot: Hs0=0.5mm Hs1=1mm Hs2=12.5mm Bs0=0.5mm Bs1=4.6mm Bs2=6mm Rs=0mm ToothWidth=3.5mm
  Stator Winding: WindingType=Whole-Coiled WindingLayers=2 ParallelBranches=1 ConductorsPerSlot=52 CoilPitch=1 EndAdjustment=0mm BaseInnerRadius=0mm TipInnerDiameter=0mm EndClearance=0mm CoilWrap=0mm SlotLiner=0.3mm WedgeThickness=0mm LayerInsulation=0mm BottomInsulation=0mm LimitedFillFactor=0.6 WdgNumberofPriodicMultipler=1 NumberOfStrands=1 WireWrap=0mm InterturnInsulation=0mm WireDiameter=0mm WireWidth=0mm WireThickness=0mm Gauge=AUTO
  Rotor Pole: Embrace=0.89 Offset=0mm ShaftDiameter=0mm Bridge=0mm Rib=0mm MagnetThickness=4mm MagnetWidth=0mm MagnetType=Arnold_Magnetics_N45_60C
setups:
  Setup1: ASSM Motor RatedOutputPower=20000W RatedVoltage=138V RatedSpeed=1000rpm OperatingTemperature=50cel LoadType=ConstPower RatedPowerFactor=0.75
